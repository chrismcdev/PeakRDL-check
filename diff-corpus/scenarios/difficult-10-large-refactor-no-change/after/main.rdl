// -------------------------------------------------------------------------
// SoC register map.
//
// 2026-07 cleanup: extracted shared register shapes into types.rdl,
// converted all literals to hexadecimal, regrouped the map by block
// (timer first, then SPI, then UART) and reformatted throughout.
// Addresses, names, fields, access and reset values are UNCHANGED.
// -------------------------------------------------------------------------

`include "types.rdl"

// ---- block-specific register shapes -------------------------------------

reg uart_baud_t {
    desc = "Baud rate divisor.";
    field {
        sw = rw;
        hw = r;
        reset = 0x1b2;
    } div[15:0];
};

reg uart_fifo_t {
    field {
        sw = r;
        hw = w;
    } lvl[7:0];
};

reg spi_clkdiv_t {
    desc = "Serial clock divisor.";
    field {
        sw = rw;
        hw = r;
        reset = 0x4;
    } div[15:0];
};

reg spi_cs_t {
    desc = "Chip-select mask.";
    field {
        sw = rw;
        hw = r;
        reset = 0xf;
    } sel[3:0];
};

reg tmr_load_t {
    field {
        sw = rw;
        hw = r;
        reset = 0x0;
    } v[31:0];
};

reg tmr_count_t {
    field {
        sw = r;
        hw = w;
    } v[31:0];
};

reg tmr_presc_t {
    desc = "Prescaler divisor.";
    field {
        sw = rw;
        hw = r;
        reset = 0x1;
    } div[15:0];
};

reg tmr_cmp_t {
    desc = "Compare threshold.";
    field {
        sw = rw;
        hw = r;
        reset = 0xffffffff;
    } v[31:0];
};

// ---- the map itself ------------------------------------------------------

addrmap soc {

    // ---- timer block @ 0x200 ----
    ctrl_t      tmr_ctrl   @ 0x200;
    stat_t      tmr_stat   @ 0x204;
    tmr_load_t  tmr_load   @ 0x208;
    tmr_count_t tmr_count  @ 0x20c;
    tmr_presc_t tmr_presc  @ 0x210;
    irq_en_t    tmr_irq_en @ 0x214;
    irq_st_t    tmr_irq_st @ 0x218;
    tmr_cmp_t   tmr_cmp    @ 0x21c;

    // ---- SPI block @ 0x100 ----
    ctrl_t       spi_ctrl   @ 0x100;
    stat_t       spi_stat   @ 0x104;
    spi_clkdiv_t spi_clkdiv @ 0x108;
    irq_en_t     spi_irq_en @ 0x10c;
    irq_st_t     spi_irq_st @ 0x110;
    tx_t         spi_tx     @ 0x114;
    rx_t         spi_rx     @ 0x118;
    spi_cs_t     spi_cs     @ 0x11c;

    // ---- UART block @ 0x0 ----
    ctrl_t      uart_ctrl   @ 0x0;
    stat_t      uart_stat   @ 0x4;
    uart_baud_t uart_baud   @ 0x8;
    uart_fifo_t uart_fifo   @ 0xc;
    irq_en_t    uart_irq_en @ 0x10;
    irq_st_t    uart_irq_st @ 0x14;
    tx_t        uart_tx     @ 0x18;
    rx_t        uart_rx     @ 0x1c;
};
