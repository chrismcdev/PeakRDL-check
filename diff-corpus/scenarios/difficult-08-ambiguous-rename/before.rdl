addrmap soc {
    reg { field { sw = rw; hw = r; reset = 0x0; } en[0:0]; } ctrl @ 0x0;
    reg { field { sw = rw; hw = r; reset = 0x5; } v[3:0]; } spare_a @ 0x10;
    reg { field { sw = rw; hw = r; reset = 0x5; } v[3:0]; } spare_b @ 0x14;
};
