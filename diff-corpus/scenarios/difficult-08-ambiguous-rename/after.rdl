addrmap soc {
    reg { field { sw = rw; hw = r; reset = 0x0; } en[0:0]; } ctrl @ 0x0;
    reg { field { sw = rw; hw = r; reset = 0x5; } v[3:0]; } dbg_x @ 0x20;
    reg { field { sw = rw; hw = r; reset = 0x5; } v[3:0]; } dbg_y @ 0x24;
};
