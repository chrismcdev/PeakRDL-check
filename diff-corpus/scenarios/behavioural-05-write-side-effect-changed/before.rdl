addrmap soc {
    reg { field { sw = rw; hw = r; reset = 0x0; } flags[3:0]; } irq @ 0x0;
};
