addrmap soc {
    reg { field { sw = rw; hw = r; reset = 0x0; onwrite = woclr; } flags[3:0]; } irq @ 0x0;
};
