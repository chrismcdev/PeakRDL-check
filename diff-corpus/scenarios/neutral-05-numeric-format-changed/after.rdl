addrmap soc {
    reg { field { sw = rw; hw = r; reset = 0; } en[0:0]; } ctrl @ 0x10;
    reg { field { sw = rw; hw = r; reset = 0xff; } div[7:0]; } clkdiv @ 20;
    reg { field { sw = rw; hw = r; reset = 12; } tune[7:0]; } trim @ 0x18;
};
