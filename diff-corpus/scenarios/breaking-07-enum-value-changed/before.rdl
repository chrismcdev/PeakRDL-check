enum speed_e {
    SLOW = 2'd0;
    FAST = 2'd1;
    TURBO = 2'd2;
};

addrmap soc {
    reg { field { sw = rw; hw = r; reset = 0x0; } en[0:0]; } ctrl @ 0x0;
    reg {
        field { sw = rw; hw = r; reset = 0x0; encode = speed_e; } sel[1:0];
    } speed @ 0x4;
};
