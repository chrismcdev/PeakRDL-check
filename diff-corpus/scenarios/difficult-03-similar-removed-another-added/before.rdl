addrmap soc {
    reg { field { sw = rw; hw = r; reset = 0x0; } en[0:0]; } ctrl @ 0x0;
    reg { field { sw = rw; hw = r; reset = 0x10; } thresh[7:0]; } wm_old @ 0x8;
};
