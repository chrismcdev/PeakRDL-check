addrmap soc {
    reg { field { sw = rw; hw = r; reset = 0x0; } en[0:0]; } ctrl @ 0x0;
    reg { field { sw = rw; hw = r; reset = 0x20; } thresh[7:0]; } wm_new @ 0x10;
};
