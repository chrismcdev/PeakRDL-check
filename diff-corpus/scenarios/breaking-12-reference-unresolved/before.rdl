enum mode_e {
    OFF = 2'd0;
    IDLE = 2'd1;
    ACTIVE = 2'd2;
};

addrmap soc {
    reg { field { sw = rw; hw = r; reset = 0x0; } en[0:0]; } ctrl @ 0x0;
    reg {
        field { sw = rw; hw = r; reset = 0x0; encode = mode_e; } state[1:0];
    } mode @ 0x4;
};
