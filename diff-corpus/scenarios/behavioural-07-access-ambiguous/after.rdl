addrmap soc {
    reg { field { sw = r; hw = rw; reset = 0x0; } cmd[7:0]; } doorbell @ 0x0;
};
