addrmap soc {
    reg { field { sw = rw; hw = r; reset = 0x0; } en[0:0]; } ctrl @ 0x0;
    reg {
        regwidth = 32;
        field { sw = rw; hw = r; reset = 0x0; } count[31:0];
    } counter @ 0x8;
    reg { field { sw = r; hw = w; } busy[0:0]; } status @ 0x10;
};
