addrmap soc {
    reg { field { sw = rw; hw = r; reset = 0x0; } en[0:0]; } ctrl @ 0x0;
    reg { field { sw = rw; hw = r; reset = 0xff; } div[7:0]; } clock_divider @ 0x4;
};
