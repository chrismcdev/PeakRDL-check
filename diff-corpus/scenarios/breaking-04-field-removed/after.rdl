addrmap soc {
    reg {
        field { sw = rw; hw = r; reset = 0x0; } en[0:0];
        field { sw = rw; hw = r; reset = 0x0; } mode[2:1];
    } ctrl @ 0x0;
    reg { field { sw = r; hw = w; } busy[0:0]; } status @ 0x4;
};
