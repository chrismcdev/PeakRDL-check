addrmap soc {
    reg { field { sw = rw; hw = r; reset = 0x80; } div[7:0]; } clkdiv @ 0x0;
};
