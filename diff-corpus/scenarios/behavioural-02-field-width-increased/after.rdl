addrmap soc {
    reg { field { sw = rw; hw = r; reset = 0x0; } mode[5:0]; } cfg @ 0x0;
};
