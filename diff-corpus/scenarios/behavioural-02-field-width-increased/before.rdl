addrmap soc {
    reg { field { sw = rw; hw = r; reset = 0x0; } mode[3:0]; } cfg @ 0x0;
};
