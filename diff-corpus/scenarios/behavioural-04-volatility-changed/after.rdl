addrmap soc {
    reg { field { sw = r; hw = r; reset = 0x0; } busy[0:0]; } status @ 0x0;
};
