addrmap soc {
    reg { field { sw = rw; hw = r; reset = 0x0; onread = rclr; } data[7:0]; } rxbuf @ 0x0;
};
