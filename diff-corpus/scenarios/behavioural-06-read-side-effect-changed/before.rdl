addrmap soc {
    reg { field { sw = rw; hw = r; reset = 0x0; } data[7:0]; } rxbuf @ 0x0;
};
