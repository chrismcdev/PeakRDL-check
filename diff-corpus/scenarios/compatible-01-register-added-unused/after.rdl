addrmap soc {
    reg { field { sw = rw; hw = r; reset = 0x0; } en[0:0]; } ctrl @ 0x0;
    reg { field { sw = r; hw = w; } fill_level[7:0]; } fifo_level @ 0x100;
};
