addrmap soc {
    reg { field { sw = r; hw = w; reset = 0x0; } pending[0:0]; } irq_status @ 0x0;
};
