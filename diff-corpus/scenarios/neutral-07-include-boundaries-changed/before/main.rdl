reg ctrl_t { field { sw = rw; hw = r; reset = 0x0; } en[0:0]; };
reg stat_t { field { sw = r; hw = w; } busy[0:0]; };

addrmap soc {
    ctrl_t ctrl   @ 0x0;
    stat_t status @ 0x4;
};
