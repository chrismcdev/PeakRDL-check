addrmap soc {
    reg limit_t { field { sw = rw; hw = r; reset = 0xff; } thresh[7:0]; };

    limit_t lim_lo @ 0x0;
    limit_t lim_hi @ 0x4;
};
