addrmap soc {
    reg {
        field { sw = rw; hw = r; reset = 0x0; } en[0:0];
        field { sw = rw; hw = r; reset = 0x0; } dbg_en[4:4];
    } ctrl @ 0x0;
};
